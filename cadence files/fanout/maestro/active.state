ADE simulation setup
Test ece115c_assign_fanout_1: ece115c_assign/fanout/schematic, simulator spectre
  Models: /w/apps4/public_libraries/tech/cadence/cadence/45nm/gpdk045_v_3_5/gpdk045/../models/spectre/gpdk045.scs[tt]
  Variables: voltage = 0.7
  Temperature: 27
  Analysis tran: stop=10n
  Output delay(?wf1 vtime('tran "/VIN") ?value1 0.55 ?edge1 "rising" ?nth1 1 ?td1 0.0 ?tol1 nil ?wf2 vtime('tran "/A") ?value2 0.55 ?edge2 "falling" ?nth2 1 ?tol2 nil ?td2 nil ?stop nil ?multiple nil) (unticked)
  Output delay(?wf1 vtime('tran "/VIN") ?value1 0.5 ?edge1 "rising" ?nth1 1 ?td1 0.0 ?tol1 nil ?wf2 vtime('tran "/A") ?value2 0.5 ?edge2 "falling" ?nth2 1 ?tol2 nil ?td2 nil ?stop nil ?multiple nil) (unticked)
  Output delay(?wf1 vtime('tran "/VIN") ?value1 0.45 ?edge1 "rising" ?nth1 1 ?td1 0.0 ?tol1 nil ?wf2 vtime('tran "/A") ?value2 0.45 ?edge2 "falling" ?nth2 1 ?tol2 nil ?td2 nil ?stop nil ?multiple nil) (unticked)
  Output delay(?wf1 vtime('tran "/VIN") ?value1 0.4 ?edge1 "rising" ?nth1 1 ?td1 0.0 ?tol1 nil ?wf2 vtime('tran "/A") ?value2 0.4 ?edge2 "falling" ?nth2 1 ?tol2 nil ?td2 nil ?stop nil ?multiple nil) (unticked)
  Output delay(?wf1 vtime('tran "/VIN") ?value1 0.35 ?edge1 "rising" ?nth1 1 ?td1 0.0 ?tol1 nil ?wf2 vtime('tran "/A") ?value2 0.35 ?edge2 "falling" ?nth2 1 ?tol2 nil ?td2 nil ?stop nil ?multiple nil) (unticked)
  Output delay(?wf1 vtime('tran "/VIN") ?value1 0.35 ?edge1 "falling" ?nth1 1 ?td1 0.0 ?tol1 nil ?wf2 vtime('tran "/A") ?value2 0.35 ?edge2 "rising" ?nth2 1 ?tol2 nil ?td2 nil ?stop nil ?multiple nil) (unticked)
  Output delay(?wf1 vtime('tran "/VIN") ?value1 0.4 ?edge1 "falling" ?nth1 1 ?td1 0.0 ?tol1 nil ?wf2 vtime('tran "/A") ?value2 0.4 ?edge2 "rising" ?nth2 1 ?tol2 nil ?td2 nil ?stop nil ?multiple nil) (unticked)
  Output delay(?wf1 vtime('tran "/VIN") ?value1 0.45 ?edge1 "falling" ?nth1 1 ?td1 0.0 ?tol1 nil ?wf2 vtime('tran "/A") ?value2 0.45 ?edge2 "rising" ?nth2 1 ?tol2 nil ?td2 nil ?stop nil ?multiple nil) (unticked)
  Output delay(?wf1 vtime('tran "/VIN") ?value1 0.5 ?edge1 "falling" ?nth1 1 ?td1 0.0 ?tol1 nil ?wf2 vtime('tran "/A") ?value2 0.5 ?edge2 "rising" ?nth2 1 ?tol2 nil ?td2 nil ?stop nil ?multiple nil) (unticked)
  Output delay(?wf1 vtime('tran "/VIN") ?value1 0.55 ?edge1 "falling" ?nth1 1 ?td1 0.0 ?tol1 nil ?wf2 vtime('tran "/A") ?value2 0.55 ?edge2 "rising" ?nth2 1 ?tol2 nil ?td2 nil ?stop nil ?multiple nil) (unticked)
  Output delay(?wf1 vtime('tran "/VIN") ?value1 0.425 ?edge1 "falling" ?nth1 1 ?td1 0.0 ?tol1 nil ?wf2 vtime('tran "/A") ?value2 0.425 ?edge2 "rising" ?nth2 1 ?tol2 nil ?td2 nil ?stop nil ?multiple nil)
  Output delay(?wf1 vtime('tran "/VIN") ?value1 0.425 ?edge1 "rising" ?nth1 1 ?td1 0.0 ?tol1 nil ?wf2 vtime('tran "/A") ?value2 0.425 ?edge2 "falling" ?nth2 1 ?tol2 nil ?td2 nil ?stop nil ?multiple nil)
  Output delay(?wf1 vtime('tran "/VIN") ?value1 0.475 ?edge1 "rising" ?nth1 1 ?td1 0.0 ?tol1 nil ?wf2 vtime('tran "/A") ?value2 0.475 ?edge2 "falling" ?nth2 1 ?tol2 nil ?td2 nil ?stop nil ?multiple nil)
  Output delay(?wf1 vtime('tran "/VIN") ?value1 0.475 ?edge1 "falling" ?nth1 1 ?td1 0.0 ?tol1 nil ?wf2 vtime('tran "/A") ?value2 0.475 ?edge2 "rising" ?nth2 1 ?tol2 nil ?td2 nil ?stop nil ?multiple nil)
  Signals: /A, /VIN
Run mode: Single Run, Sweeps and Corners
Setup values for test ece115c_assign_fanout_1: voltage = .7:.05:1.1
