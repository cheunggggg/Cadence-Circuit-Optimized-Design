ADE simulation setup
Run mode: Single Run, Sweeps and Corners
Tests:
  ece115c_assign_fanout_1: ece115c_assign/fanout/schematic, simulator spectre
    Variables: voltage = .7:.05:1.1
