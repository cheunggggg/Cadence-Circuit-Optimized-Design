ADE simulation setup
Test ece115c_assign_final_1: ece115c_assign/final/schematic, simulator spectre
  Models: /w/apps4/public_libraries/tech/cadence/cadence/45nm/gpdk045_v_3_5/gpdk045/../models/spectre/gpdk045.scs[tt]
  Variables: n2c1 = .69u; n2c1end = 3.46u; nic1 = .35u; p2c1 = .52u; p2c1end = 2.6u; pic1 = .52u; n2c2 = .89u; n2c3 = 4.6u; n2c4 = 2.53u; n3c2 = 1.72u; n3c2end = 6.67u; n3c3 = 8.87u; n3c4 = 4.87u; n4c3 = 14.41u; n4c3end = 22.34u; n4c4 = 7.93u; nic2 = .45u; nic3 = 2.61u; nic4 = 1.26u; p2c2 = .67u; p2c3 = 2.3u; p2c4 = 1.89u; p3c2 = .86u; p3c2end = 3.34u; p3c3 = 4.43u; p3c4 = 2.43u; p4c3 = 5.4u; p4c3end = 8.38u; p4c4 = 2.97u; pic2 = .67u; pic3 = 3.45u; pic4 = 1.89u; n5c4 = 11.74u; n5c4end = 22.55u; p5c4 = 3.52u; p5c4end = 6.75u; n4c4end = 0; p4c4end = 0; c0 = 0:1:1v; g0 = 0:1:1v; g1 = 0:1:1v; p0 = 1.1; p1 = 1.1; p2 = 1.1; p3 = 1.1; g2 = 0:1:1v; g3 = 0; vdd = 1.1
  Temperature: 27
  Analysis tran: stop=20n
  Output average(itime('tran "/V3/PLUS"))
  Signals: /C0, /C1, /C2, /C3, /C4
Run mode: Single Run, Sweeps and Corners
Setup values for test ece115c_assign_final_1: c0 = 0; g0 = 0; g1 = 0; g2 = 0
