ADE simulation setup
Test ece115c_assign_power_1: ece115c_assign/power/schematic, simulator spectre
  Models: /w/apps4/public_libraries/tech/cadence/cadence/45nm/gpdk045_v_3_5/gpdk045/../models/spectre/gpdk045.scs[tt]
  Variables: VDD = 0.5:0.05:1.1
  Temperature: 27
  Analysis tran: stop=10n
  Output average(itime('tran "/V1/PLUS"))
  Output (average(itime('tran "/V1/PLUS")) * VDD)
  Signals: /V1/PLUS (terminal)
Run mode: Single Run, Sweeps and Corners
