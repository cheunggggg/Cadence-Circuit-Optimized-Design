ADE simulation setup
Run mode: Single Run, Sweeps and Corners
Tests:
  ece115c_assign_power_1: ece115c_assign/power/schematic, simulator spectre
    Variables: VDD = 0.5:0.05:1.1
